Minimum Delay - four-stage CMOS inverter chain
* AUTO-GENERATED by export_ltspice.py
* Educational LEVEL=1 MOS models; NOT a foundry PDK or sign-off model.
* KP is estimated from the Stage-1 effective R around Vout = VDD/2.
* Explicit Cpar elements represent the Stage-1 output diffusion + wire capacitance.

.param VDD=1.8
.param LCH=0.18u
VDD_SRC vdd 0 {VDD}
VIN in 0 PULSE(0 {VDD} 1n 20p 20p 5n 10n)

M1N n1 in 0 0 NMOD W=0.22u L={LCH}
M1P n1 in vdd vdd PMOD W=0.44u L={LCH}
CDIFF1 n1 0 0.2904f
CWIRE1 n1 0 0.2f

M2N n2 n1 0 0 NMOD W=0.635821823u L={LCH}
M2P n2 n1 vdd vdd PMOD W=1.27164365u L={LCH}
CDIFF2 n2 0 0.839284806f
CWIRE2 n2 0 0.2f

M3N n3 n2 0 0 NMOD W=1.80551427u L={LCH}
M3P n3 n2 vdd vdd PMOD W=3.61102853u L={LCH}
CDIFF3 n3 0 2.38327883f
CWIRE3 n3 0 0.2f

M4N out n3 0 0 NMOD W=5.0644625u L={LCH}
M4P out n3 vdd vdd PMOD W=10.128925u L={LCH}
CDIFF4 out 0 6.6850905f
CWIRE4 out 0 0.2f

CLOAD out 0 58.79808f

* LEVEL=1 long-channel MOS models; KP values are illustrative estimates.
.model NMOD NMOS (LEVEL=1 VTO=0.4 KP=7.17703349e-05 LAMBDA=0 GAMMA=0.4 PHI=0.7 TOX=5n CGSO=75p CGDO=75p)
.model PMOD PMOS (LEVEL=1 VTO=-0.4 KP=3.58851675e-05 LAMBDA=0 GAMMA=0.4 PHI=0.7 TOX=5n CGSO=75p CGDO=75p)

.temp 27
.options plotwinsize=0 reltol=1e-4 abstol=1e-15 vntol=1e-6
.save V(in) V(n1) V(n2) V(n3) V(out)
.tran 0 25n 0 2p

* Four inverters give non-inverting overall polarity.
* Measure propagation delay from input 50% crossing to output 50% crossing.
.meas TRAN tplh TRIG V(in) VAL={VDD/2} RISE=1 TARG V(out) VAL={VDD/2} RISE=1
.meas TRAN tphl TRIG V(in) VAL={VDD/2} FALL=1 TARG V(out) VAL={VDD/2} FALL=1
.meas TRAN tpd_avg PARAM (tplh+tphl)/2

.end

* Stage sizing factors: 1, 2.89009919, 8.20688303, 23.0202841
* Python model external load: 58.79808 fF
* Approximate mid-swing KP_N/KP_P: 7.17703349e-05 / 3.58851675e-05 A/V^2
